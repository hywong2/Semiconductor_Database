// Design: fun_lib/Inverter_s45
simulator lang=spice
*Used for ALD1103 chips
*Note: Properties L=10u W=880u
.MODEL NMOS NMOS (LEVEL=3
+TPG=1 TOX=6.00E-8 LD=2.08E-6 WD=4.00E-7
+U0= 1215 VTO=0.73 THETA=0.222 RS=0.74 RD=0.74 DELTA=2.5
+NSUB=1.57E16 XJ=1.3E-6 VMAX=4.38E6 ETA=0.913 KAPPA=0.074 NFS=3E11
+CGSO=5.99E-10 CGDO=5.99E-10 CGBO=4.31E-10 PB=0.90 XQC=0.4)
*
*Used for ALD1103 chips
*Note: Properties L=10u W=880u
.MODEL PMOS PMOS (LEVEL=3
+TPG=1 TOX=6.00E-8 LD=2.08E-6 WD=4.00E-7
+U0=550 VTO=-0.89 THETA=0.222 RS=0.74 RD=0.74 DELTA=2.5
+NSUB=1.57E16 XJ=1.3E-6 VMAX=4.38E6 ETA=0.913 KAPPA=0.074 NFS=3E11
+CGSO=5.99E-10 CGDO=5.99E-10 CGBO=4.31E-10 PB=0.90 XQC=0.4)
simulator lang=spectre
global 0
include "/apps/cadence/gpdk/gpdk045_v_5_0/gpdk045/../models/spectre/gpdk045.scs" section=mc

// fun_lib/Inverter_s45/schematic
NM0 (Vout Vin net06 net06) NMOS w=880u l=10u nf=1 m=(1)
PM0 (Vout Vin net08 net08) PMOS w=(2524.61u) l=10u nf=1 m=(1)
V0 (net09 0) vsource dc=3 type=dc
V2 (Vin 0) vsource type=pulse val0=0 val1=3 period=500.0m
R1 (net06 0) resistor r=9772372.209558113 tc1=0 tc2=0 c=0
R0 (net09 net08) resistor r=912010.8393559096 tc1=0 tc2=0 c=0
simulatorOptions options temp=27
dc dc dev=V2 param=dc start=0 stop=3
save Vin Vout
